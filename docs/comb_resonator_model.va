// Reduced-order model of `comb_resonator` - generated by soidlc
`include "disciplines.vams"

module comb_resonator_rom(d, s, g);
  inout d, s, g;
  electrical d, s, g;
  electrical q1, v1, electrical q2, v2, electrical q3, v3;
  parameter real VDC   = 30;
  parameter real DCDXD = 5.312513e-09;
  parameter real DCDXS = 5.312513e-09;
  parameter real CFT   = 2.018755e-15;
  parameter real W1 = 1.943531e+05;
  parameter real Z1 = 8.106586e-04;
  parameter real UD1 = -1.321269e+04;
  parameter real US1 = 1.321269e+04;
  parameter real W2 = 4.737295e+06;
  parameter real Z2 = 1.000000e-04;
  parameter real UD2 = 4.806412e+02;
  parameter real US2 = -4.806085e+02;
  parameter real W3 = 4.740891e+06;
  parameter real Z3 = 1.000000e-04;
  parameter real UD3 = -5.728187e+02;
  parameter real US3 = 5.727302e+02;
  real F;
  analog begin
    F = 0.5 * DCDXD * V(d, g) * V(d, g);
    I(q1) <+ ddt(V(q1)) - V(v1);
    I(v1) <+ ddt(V(v1)) + 2.0*Z1*W1*V(v1) + W1*W1*V(q1) - UD1*F;
    I(q2) <+ ddt(V(q2)) - V(v2);
    I(v2) <+ ddt(V(v2)) + 2.0*Z2*W2*V(v2) + W2*W2*V(q2) - UD2*F;
    I(q3) <+ ddt(V(q3)) - V(v3);
    I(v3) <+ ddt(V(v3)) + 2.0*Z3*W3*V(v3) + W3*W3*V(q3) - UD3*F;
    I(s, g) <+ VDC * DCDXS * (US1*V(v1) + US2*V(v2) + US3*V(v3));
    I(d, s) <+ ddt(CFT * (V(d) - V(s)));
  end
endmodule
