* Butterworth-Van Dyke model of `comb_resonator` - generated by soidlc
* bias V_dc = 30 V; series resonance = 30932.3 Hz
* motional branch: Rm=7.1062e+07 Lm=2.2551e+05 Cm=1.1739e-16
.subckt comb_resonator_rom drive sense gnd
Lm drive n1 2.2551e+05
Cm n1   n2 1.1739e-16
Rm n2   sense 7.1062e+07
C0d drive gnd 2.0188e-13
C0s sense gnd 2.0188e-13
Cft drive sense 2.0188e-15
.ends
